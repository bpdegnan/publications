* ============================================================
* rfidfull.cir
* Brian Degnan, 2026JUN20 version
* Please see notes in the paper
* Licensed under GPL-3.  Please improve and publish.
*
* The whole chain in one deck: ideal 900 MHz reader -> free space (1 m)
* -> dipole tag antenna -> strap/match -> cross-coupled charge pump
* -> backscatter modulator -> reader homodyne detection. All active
* devices are from the abstract device (abnmos / abpmos).
*
* ============================================================
.lib "$SPICE_LIB/sky130.lib.spice" tt
.include "$SPICE_DEVICES/devices.cir"

* ---- global parameters ----
.param fc    = 900e6
.param w     = {2*3.141592653589793*fc}
.param Pin   = 1.0                  ; reader power into its antenna [W]
.param Vamp  = {sqrt(8*73.08*Pin)}  ; reader Thevenin amplitude (~24.16 V)

* antenna self/mutual at 1 m (validated dipole two-port)
.param Rself = 73.08
.param Lself = 7.515n               ; wL = +42.5 ohm
.param Cmatch= 4.16p                ; series C conjugates the reader antenna
.param K12   = 0.1481               ; mutual coupling (M = 1.113 nH)
.param R21   = 0.571                ; mutual (radiative) resistance [ohm]

* strap + matching (TUNE for your rectifier + antenna reactance)
.param Lstrap= 2n
.param Rstrap= 1.0
.param Lmat  = 35n
.param Cmat  = 0.6p

* backscatter modulator control
.param Vmodhi= 2.5                  ; modulator gate high = tag supply rail (vdd ~2.4 V).
                                    ; Must exceed the rfp/rfn RF swing, else Vgs goes
                                    ; negative on the RF peaks and the switch never
                                    ; fully turns "on" (width then does nothing).
.param Tbit  = 200n                 ; one backscatter data bit, shorter Gen2
.param Nmod  = 128                  ; modulator switch width = 128 parallel abnmos
                                    ; UNIT cells (m=Nmod). Widen ONLY by integer
                                    ; copies of the abstract unit device, never w.

* =====================================================================
*  1) READER  (ideal CW, conjugate-matched to its antenna, 1 W)
* =====================================================================
Vtx   txin 0   DC 0  SIN(0 {Vamp} {fc})
Rsrc  txin nrs {Rself}
Csrc  nrs  nr1 {Cmatch}
Vsns1 nr1  nr2 0                       ; ammeter: reader antenna current I1
Brad1 nr2  nr3 V = {R21}*i(Vsns2)     ; radiative coupling: EMF from tag I2
Rrad1 nr3  nr4 {Rself}
L1    nr4  0   {Lself}

* =====================================================================
*  2) FREE SPACE @ 1 m = two-port coupling (reactive K12 + radiative R21)
* =====================================================================
K12   L1 L2 {K12}

* =====================================================================
*  3) TAG DIPOLE (floating/differential), EMF = Z21*I1 via K12 + Brad2
* =====================================================================
L2    tp   ta  {Lself}
Vsns2 ta   tb  0                       ; ammeter: tag antenna current I2
Brad2 tb   tc  V = {R21}*i(Vsns1)     ; radiative coupling: EMF from reader I1
Rrad2 tc   tn  {Rself}

* =====================================================================
*  4) STRAP + CONJUGATE MATCH (differential) -> rfp, rfn
* =====================================================================
Lsp   tp   m1  {Lstrap/2}
Rsp   m1   m2  {Rstrap/2}
Lmp   m2   rfp {Lmat/2}
Lsn   tn   m3  {Lstrap/2}
Rsn   m3   m4  {Rstrap/2}
Lmn   m4   rfn {Lmat/2}
Cm    rfp  rfn {Cmat}
Rcmp  rfp  0   1e6                     ; weak common-mode reference
Rcmn  rfn  0   1e6

* =====================================================================
*  5) CROSS-COUPLED CHARGE PUMP (one stage)   (drain gate source bulk)
* =====================================================================
XMN1  rfp rfn 0   0   abnmos
XMN2  rfn rfp 0   0   abnmos
XMP1  rfp rfn vdd vdd abpmos
XMP2  rfn rfp vdd vdd abpmos
Cstor vdd 0   2.5p
Rload vdd 0   100k                     ; ~9 uW @ ~1 V light digital load

* =====================================================================
*  6) BACKSCATTER MODULATOR
*     shunt abnmos across rfp-rfn, gated by tag data. ON (state B) shorts the
*     RF input -> detunes/loads the tag -> changes the tag's reflection and
*     starves the rectifier. OFF (state A) -> matched, harvesting. The tag
*     sends the data pattern 1 0 1 1 0 0 (200 ns/bit; first bit at 300 ns).
*     The CW quiet window before 300 ns lets the rectifier AND the reader's
*     homodyne settle, and is where the carrier canceller is calibrated.
*     It all fits on the graph: Gen2 bits are ~10^3-10^6x slower.
* =====================================================================
Vmod  gmod 0   PWL(0 0  300n 0  301n {Vmodhi}  500n {Vmodhi}  501n 0
+                  700n 0  701n {Vmodhi}  1100n {Vmodhi}  1101n 0  1500n 0)
* shunt switch across the RF input; m=Nmod parallel unit abnmos for low Ron so
* the ON state visibly detunes/loads the tag -> deep backscatter (state B).
XMmod rfp  gmod rfn 0  abnmos m={Nmod}

* =====================================================================
*  7) READER FRONT END: carrier cancellation -> homodyne I/Q
* =====================================================================
* The received antenna current i(Vsns1) is dominated by the reader's own 1 W CW
* carrier by monostatic self-jamming. at 1 m the backscatter is only ~0.03% of
* it, so the down-converted data step (~20 uV) is buried under an ~82 mV self-jam
* pedestal and in a real reader it would saturate the mixer/ADC.
*
Vgc   gcn 0    DC 0                    ; cos-weight  (set by calibration, pass 2)
Vgs   gsn 0    DC 0                    ; sin-weight
Brx   rxres 0  V = i(Vsns1) - v(gcn)*cos({w}*time) - v(gsn)*sin({w}*time)

* Each homodyne channel: mixer -> 2-pole RC LPF (~8 MHz; kills the 2*fc=1.8 GHz
* product, passes the 2.5 MHz data; 2nd stage high-Z so it doesn't load the 1st).
* bsmag = |I+jQ| removes the round-trip-phase ambiguity.

* --- homodyne BEFORE cancellation (self-jammed reference, for the figure) ---
Bdi0  di0  0   V = i(Vsns1)*cos({w}*time)
Rli0a di0  d0a 10k
Cli0a d0a  0   2p
Rli0b d0a  dif0 100k
Cli0b dif0 0   0.2p
Bdq0  dq0  0   V = i(Vsns1)*sin({w}*time)
Rlq0a dq0  q0a 10k
Clq0a q0a  0   2p
Rlq0b q0a  qbb0 100k
Clq0b qbb0 0   0.2p
Bmag0 bsmag0 0 V = sqrt(v(dif0)*v(dif0) + v(qbb0)*v(qbb0))

* --- homodyne AFTER cancellation (operates on the residual rxres) ---
Bdi   di   0   V = v(rxres)*cos({w}*time)
Rlpi1 di   dia 10k
Clpi1 dia  0   2p
Rlpi2 dia  dif 100k
Clpi2 dif  0   0.2p
Bdq   dq   0   V = v(rxres)*sin({w}*time)
Rlpq1 dq   qia 10k
Clpq1 qia  0   2p
Rlpq2 qia  qbb 100k
Clpq2 qbb  0   0.2p
Bmag  bsmag 0  V = sqrt(v(dif)*v(dif) + v(qbb)*v(qbb))

* =====================================================================
*  analysis
* =====================================================================
.options gmin=1e-12 reltol=1e-4 abstol=1e-9 vntol=1e-7 method=gear
.tran 10p 1500n 0 10p uic
.control
  * ---- pass 1: canceller OFF -- learn the self-jam carrier leakage ----
  run
  meas tran idc AVG v(dif0) from=260n to=295n  ; homodyne I DC, settled CW quiet window
  meas tran qdc AVG v(qbb0) from=260n to=295n  ; homodyne Q DC
  * complex weight that nulls the leakage: <cos^2>=<sin^2>=1/2 -> G = 2*DC
  alter Vgc = 2*idc
  alter Vgs = 2*qdc
  echo "carrier-cancellation weights: Gc =" $&idc " x2,  Gs =" $&qdc " x2"

  * ---- pass 2: canceller ON -- the tag reply is now recoverable ----
  run
  meas tran vdd_ss  AVG v(vdd) from=260n to=295n
  meas tran vdd_mod MIN v(vdd) from=300n to=1500n
  meas tran bs_off  AVG v(bsmag) from=560n to=690n   ; reader, 'data 0' bit (state A)
  meas tran bs_on   AVG v(bsmag) from=900n to=1080n  ; reader, 'data 1' bit (state B)
  print vdd_ss vdd_mod bs_off bs_on
  wrdata rfidlink.csv v(vdd) v(rfp) v(rfn) v(bsmag0) v(bsmag) v(dif) v(qbb) v(gmod)
  echo "tag side : vdd (supply), rfp/rfn (RF input)."
  echo "reader   : bsmag0 (before cancellation, buried), bsmag/dif/qbb (after)."
.endc
.end
